* NGSPICE file created from sky130_fd_bd_sram__sram_sp_cell_opt1.ext - technology: sky130A

.subckt sky130_fd_bd_sram__sram_sp_cell_opt1 BL BR VGND VPWR VPB VNB WL Q
X0 Q_bar WL BR VNB sky130_fd_pr__special_nfet_pass w=0.14 l=0.15
X1 Q Q_bar VGND VNB sky130_fd_pr__special_nfet_latch w=0.21 l=0.15
X2 BL WL Q VNB sky130_fd_pr__special_nfet_pass w=0.14 l=0.15
*X3 Q WL Q VPB sky130_fd_pr__special_pfet_pass w=0.07 l=0.095
*X4 Q_bar WL Q_bar VPB sky130_fd_pr__special_pfet_pass w=0.07 l=0.095
X5 VPWR Q Q_bar VPB sky130_fd_pr__special_pfet_pass w=0.14 l=0.15
X6 Q Q_bar VPWR VPB sky130_fd_pr__special_pfet_pass w=0.14 l=0.15
X7 VGND Q Q_bar VNB sky130_fd_pr__special_nfet_latch w=0.21 l=0.15
.ends
* 8T1C Analog CIM Cell (6T Core + 2T Read Port + 1C MOM Cap)

.subckt cim_cell_8t1c BL BR VGND VPWR VPB VNB WL RWL RBL
* 6T Core (using exposed Q node)
Xcore BL BR VGND VPWR VPB VNB WL Q sky130_fd_bd_sram__sram_sp_cell_opt1

* 2T Read Port
* M_read1: connects to Q, source to VGND
* M_read2: connects to RWL, source to M_read1 drain, drain to RBL
XMread1 read_int Q VGND VNB sky130_fd_pr__nfet_01v8 w=0.42 l=0.15
XMread2 RBL RWL read_int VNB sky130_fd_pr__nfet_01v8 w=0.42 l=0.15

* 1C MOM Cap (extracted layout capacitance placeholder for LVS)
* If the MOM is extracted as a parasitic from RBL to somewhere, we don't need it in LVS
* We will rely on Magic's ext2spice. If we draw the MOM cap on RBL, it adds parasitic C to RBL.
* For LVS, we omit the explicit capacitor if we extract it as parasitic, or we include it if we extract it as a device.
* We'll just define the 8T transistors for now. The MOM cap is a pure parasitic in Magic.
.ends
