* MC offset sample (auto-generated by mc_offset.py)
.include "../../rtl/analog_cim/sense_amp_mm.spice"
.lib "/foss/pdks/sky130A/libs.tech/ngspice/sky130.lib.spice" tt
Vvdd VDD 0 DC 1.8
Vvss VSS 0 DC 0
Vclk CLK 0 PULSE(0 1.8 5n 0.1n 0.1n 10n 20n)
Vinp INP 0 DC 1.187500
Vinn INN 0 DC 1.212500
Xsa VDD VSS CLK INP INN OUTP OUTN strongarm_comparator_mm off_inp=0.001389 off_inn=0.010345 off_lnp=0.000879 off_lnn=-0.000627
.options reltol=1e-3 abstol=1e-9 vntol=1e-3
.control
  tran 0.02n 20n
  save v(OUTP)
  run
  meas tran outp find v(OUTP) at=9.5n
  print outp
  quit
.endc
.end
