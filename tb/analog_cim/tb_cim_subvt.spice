* Subthreshold low-energy CIM array  --  the path to FUNCTIONAL sub-100 fJ.
*
* The strong full-swing cell (~300 uA) is why the linear-region energy is high.
* THE KNOB: drive the activation "high" level WELL BELOW VDD (~0.5-0.8 V) so the
* tail transistor conducts only nA-uA. This simultaneously:
*   - keeps the 100 fF bitline in the LINEAR region (partial discharge => the
*     differential Vdiff still ENCODES sum(X*W) -> a real, readable analog MAC), and
*   - cuts per-MAC energy ~10-100x (energy ~ Q*V, and Q is the small subthreshold charge).
* The cost: Vdiff shrinks to ~mV-tens-of-mV, so a sense amp / comparator is required.
* (That sense-amp energy then AMORTIZES across the column -- the legitimate version
*  of the amortization argument.)
*
* EXPERIMENT (run the sweep, don't guess):
*   1. Sweep VXHI  = 0.5, 0.6, 0.7, 0.8, 1.0, 1.2, 1.8 V   (edit Vx0/Vx1 amplitude)
*      -> plot recharge energy/MAC vs VXHI. Energy should fall steeply as VXHI drops.
*   2. At each VXHI, sweep ACTIVE ROWS = 1,2,3,4 (enable Vx2/Vx3)
*      -> Vdiff must scale ~linearly with active count (that linearity = the analog sum).
*   The sweet spot = lowest VXHI where Vdiff is still linear AND above sense-amp noise.

.include "../../rtl/analog_cim/cim_cell.spice"
.lib "/foss/pdks/sky130A/libs.tech/ngspice/sky130.lib.spice" tt

Vpwr VPWR 0 DC 1.8
Vgnd VGND 0 DC 0

* Precharge: low = precharge to 1.8V (0-4ns), high = evaluate (4-12ns), recharge at 12ns
Vpre PRE 0 PULSE(0 1.8 4n 0.1n 0.1n 8n 20n)
Xpre_l BL     PRE VPWR VPWR sky130_fd_pr__pfet_01v8 w=2.0 l=0.15
Xpre_r BL_bar PRE VPWR VPWR sky130_fd_pr__pfet_01v8 w=2.0 l=0.15

* Standard 100 fF bitline -- subthreshold current keeps it from railing.
Cbl     BL     0 100f
Cbl_bar BL_bar 0 100f

* Weights: Row0,1,3 = 1 ; Row2 = 0
Vw0 W0 0 DC 1.8
Vw0_bar W0_bar 0 DC 0
Vw1 W1 0 DC 1.8
Vw1_bar W1_bar 0 DC 0
Vw2 W2 0 DC 0
Vw2_bar W2_bar 0 DC 1.8
Vw3 W3 0 DC 1.8
Vw3_bar W3_bar 0 DC 0

* SUBTHRESHOLD activation: "high" = 0.7 V (NOT 1.8 V) <-- the energy knob; sweep it.
* Longer 4 ns evaluate window because subthreshold current is small.
Vx0 X0 0 PULSE(0 0.7 6n 0.1n 0.1n 4n 20n)
Vx1 X1 0 PULSE(0 0.7 6n 0.1n 0.1n 4n 20n)
Vx2 X2 0 DC 0
Vx3 X3 0 DC 0

Xrow0 VGND VPWR X0 W0 W0_bar BL BL_bar cim_cell
Xrow1 VGND VPWR X1 W1 W1_bar BL BL_bar cim_cell
Xrow2 VGND VPWR X2 W2 W2_bar BL BL_bar cim_cell
Xrow3 VGND VPWR X3 W3 W3_bar BL BL_bar cim_cell

.control
  tran 0.05n 15n
  run

  * Readout AFTER the evaluate pulse. Must be PARTIAL (|Vdiff| << 1.8 V) and must
  * grow with the number of active rows -- that is the analog accumulation.
  meas tran vbl_final     find v(BL)     at=10.5n
  meas tran vbl_bar_final find v(BL_bar) at=10.5n
  let v_diff = v(BL) - v(BL_bar)
  meas tran vdiff_final find v_diff at=10.5n

  * True dynamic energy: supply power integrated over the recharge restore phase.
  let p_pwr = -i(vpwr) * 1.8
  meas tran energy_precharge integ p_pwr from=12n to=15n

  print vbl_final
  print vbl_bar_final
  print vdiff_final
  print energy_precharge
  quit
.endc

.end
